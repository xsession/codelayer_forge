* DC motor on a full H-bridge, 20 kHz PWM, sign-magnitude drive.
* Used with backend ngspice-shared (libngspice): one transient runs for the
* whole co-simulation, so the switching ripple, DC-link sag and winding
* current carry across co-simulation steps.
*
* Inputs (external sources, values set by Embeddyn each step):
*   Vdutyp  positive duty 0..1 (drives leg A)
*   Vdutyn  negative duty 0..1 (drives leg B)
*   Vbus    supply voltage
*   Vbemf   back-EMF in volts
* Outputs (vectors read by Embeddyn):
*   i(Vsense)  winding current     V(a,b)  bridge output voltage
*   V(pin)     power drawn from the supply
* {{signal}} placeholders take the signal's initial value at start.

.param rmotor={{electrical.motor_resistance}}
.param lmotor={{electrical.motor_inductance}}

* Supply with source resistance and DC-link capacitor
Vbus vsrc 0 dc 0 external
Rsrc vsrc vbus 0.05
Cbus vbus 0 470u ic={{electrical.supply_voltage}}
Bpin pin 0 V = -V(vsrc)*I(Vbus)

* PWM carrier: 20 kHz triangle kept inside 0..1 by more than the switch
* hysteresis, so duty 0 and 1 hold a switch fully on or off. The 10 ns flat
* top avoids an ngspice breakpoint collision at the period boundary
* (TR + TF = PER makes the transient fail with "timestep too small").
Vtri tri 0 PULSE(0.01 0.99 0 24.995u 24.995u 10n 50u)
Vdutyp dutyp 0 dc 0 external
Vdutyn dutyn 0 dc 0 external

* Leg A: high side on while dutyp > carrier, low side complementary
S1 vbus a dutyp tri sw
S2 a 0 tri dutyp sw
* Leg B
S3 vbus b dutyn tri sw
S4 b 0 tri dutyn sw
.model sw sw(vt=0 vh=0.001 ron=0.02 roff=1meg)
* Bleed resistors keep the bridge nodes defined while switches change over
Rbleeda a 0 100k
Rbleedb b 0 100k

* Motor winding: R, L, back-EMF; Vsense measures the current a -> b
Vsense a wa dc 0
Rmotor wa wl {rmotor}
Lmotor wl wb {lmotor} ic={{electrical.motor_current}}
Vbemf wb b dc 0 external
.end
