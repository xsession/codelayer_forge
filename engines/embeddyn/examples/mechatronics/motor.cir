* Embeddyn DC motor electrical macro-step template
.param duty={{electrical.pwm_duty}}
.param supply={{electrical.supply_voltage}}
.param bemf={{electrical.back_emf}}
.param dt={{dt}}
Vdrive drive 0 {duty*supply}
Vbemf motor 0 {bemf}
Rmotor drive winding {{electrical.motor_resistance}}
Lmotor winding motor {{electrical.motor_inductance}} ic={{electrical.motor_current}}
.tran {dt/20} {dt}
.control
run
* A production model should wrdata cosim.csv with aliased output vectors.
quit
.endc
.end
